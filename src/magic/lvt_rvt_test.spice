* NGSPICE file created from lvt_rvt_test.ext - technology: sky130A

.subckt lvt_rvt_test
X0 w_n420_n320# a_n60_210# a_n100_n20# w_n420_n320# sky130_fd_pr__pfet_01v8 ad=0.35 pd=2.7 as=0.35 ps=2.7 w=1 l=0.15
X1 w_n420_n320# a_310_210# a_250_n20# w_n420_n320# sky130_fd_pr__pfet_01v8_lvt ad=0.35 pd=2.7 as=0.35 ps=2.7 w=1 l=0.35
.ends
