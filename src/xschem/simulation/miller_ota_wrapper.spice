** sch_path: /home/tarator/Desktop/IEEE_TTSKY26a_Miller_OTA/src/xschem/miller_ota_wrapper.sch
.subckt miller_ota_wrapper VDPWR VGND ua[0] ua[1]
*.iopin VDPWR
*.iopin VGND
*.ipin ua[0]
*.opin ua[1]
x1 VDPWR ua[1] ua[1] ua[0] VGND miller_ota
.ends

* expanding   symbol:  miller_ota.sym # of pins=5
** sym_path: /home/tarator/Desktop/IEEE_TTSKY26a_Miller_OTA/src/xschem/miller_ota.sym
** sch_path: /home/tarator/Desktop/IEEE_TTSKY26a_Miller_OTA/src/xschem/miller_ota.sch
.subckt miller_ota VDPWR out inn inp VGND
*.ipin inp
*.opin out
*.ipin inn
*.iopin VDPWR
*.iopin VGND
XMs1 net1 net1 VDPWR VDPWR sky130_fd_pr__pfet_01v8 L=10 W=0.5 nf=1 ad=0.145 as=0.145 pd=1.58 ps=1.58 nrd=0.58 nrs=0.58 sa=0 sb=0
+ sd=0 mult=1
XMs3 vref net1 net2 VGND sky130_fd_pr__nfet_01v8 L=1 W=2 nf=1 ad=0.58 as=0.58 pd=4.58 ps=4.58 nrd=0.145 nrs=0.145 sa=0 sb=0 sd=0
+ mult=1
XMs2 net1 net2 VGND VGND sky130_fd_pr__nfet_01v8 L=0.15 W=1 nf=1 ad=0.29 as=0.29 pd=2.58 ps=2.58 nrd=0.29 nrs=0.29 sa=0 sb=0 sd=0
+ mult=1
XMr3 net2 net2 VGND VGND sky130_fd_pr__nfet_01v8 L=1 W=5 nf=1 ad=1.45 as=1.45 pd=10.58 ps=10.58 nrd=0.058 nrs=0.058 sa=0 sb=0 sd=0
+ mult=1
XMr1 net2 vref VDPWR VDPWR sky130_fd_pr__pfet_01v8 L=1 W=5.3 nf=1 ad=1.537 as=1.537 pd=11.18 ps=11.18 nrd=0.0547169811320755
+ nrs=0.0547169811320755 sa=0 sb=0 sd=0 mult=1
XMr2 vref vref VDPWR VDPWR sky130_fd_pr__pfet_01v8 L=1 W=5.3 nf=1 ad=1.537 as=1.537 pd=11.18 ps=11.18 nrd=0.0547169811320755
+ nrs=0.0547169811320755 sa=0 sb=0 sd=0 mult=1
XMr4 vref net2 net3 net3 sky130_fd_pr__nfet_01v8 L=1 W=5 nf=1 ad=1.45 as=1.45 pd=10.58 ps=10.58 nrd=0.058 nrs=0.058 sa=0 sb=0 sd=0
+ mult=4 m=4
XR1 VGND net3 VGND sky130_fd_pr__res_xhigh_po W=4 L=25.5 mult=1
XM4 net5 net4 VGND VGND sky130_fd_pr__nfet_01v8 L=2 W=0.685 nf=1 ad=0.19865 as=0.19865 pd=1.95 ps=1.95 nrd=0.423357664233577
+ nrs=0.423357664233577 sa=0 sb=0 sd=0 mult=1
XM3 net4 net4 VGND VGND sky130_fd_pr__nfet_01v8 L=2 W=0.685 nf=1 ad=0.19865 as=0.19865 pd=1.95 ps=1.95 nrd=0.423357664233577
+ nrs=0.423357664233577 sa=0 sb=0 sd=0 mult=1
XM1 net4 inn net6 net6 sky130_fd_pr__pfet_01v8_lvt L=0.5 W=1.25 nf=1 ad=0.3625 as=0.3625 pd=3.08 ps=3.08 nrd=0.232 nrs=0.232 sa=0
+ sb=0 sd=0 mult=1
XM2 net5 inp net6 net6 sky130_fd_pr__pfet_01v8_lvt L=0.5 W=1.25 nf=1 ad=0.3625 as=0.3625 pd=3.08 ps=3.08 nrd=0.232 nrs=0.232 sa=0
+ sb=0 sd=0 mult=1
XM9 net8 net8 net7 VGND sky130_fd_pr__nfet_01v8 L=2 W=0.65 nf=1 ad=0.1885 as=0.1885 pd=1.88 ps=1.88 nrd=0.446153846153846
+ nrs=0.446153846153846 sa=0 sb=0 sd=0 mult=1
XM10 net7 net7 VGND VGND sky130_fd_pr__nfet_01v8 L=2 W=0.65 nf=1 ad=0.1885 as=0.1885 pd=1.88 ps=1.88 nrd=0.446153846153846
+ nrs=0.446153846153846 sa=0 sb=0 sd=0 mult=1
XMc net9 net8 net5 VGND sky130_fd_pr__nfet_01v8 L=2 W=0.65 nf=1 ad=0.1885 as=0.1885 pd=1.88 ps=1.88 nrd=0.446153846153846
+ nrs=0.446153846153846 sa=0 sb=0 sd=0 mult=2 m=2
XC1 out net9 sky130_fd_pr__cap_mim_m3_1 W=10.5 L=10.5 MF=1
XM5 out net5 VGND VGND sky130_fd_pr__nfet_01v8 L=2 W=0.685 nf=1 ad=0.19865 as=0.19865 pd=1.95 ps=1.95 nrd=0.423357664233577
+ nrs=0.423357664233577 sa=0 sb=0 sd=0 mult=30 m=30
XM8 net8 vref VDPWR VDPWR sky130_fd_pr__pfet_01v8 L=1 W=5.3 nf=1 ad=1.537 as=1.537 pd=11.18 ps=11.18 nrd=0.0547169811320755
+ nrs=0.0547169811320755 sa=0 sb=0 sd=0 mult=1
XM7 out vref VDPWR VDPWR sky130_fd_pr__pfet_01v8 L=1 W=5.3 nf=1 ad=1.537 as=1.537 pd=11.18 ps=11.18 nrd=0.0547169811320755
+ nrs=0.0547169811320755 sa=0 sb=0 sd=0 mult=15 m=15
XM6 net6 vref VDPWR VDPWR sky130_fd_pr__pfet_01v8 L=1 W=5.3 nf=1 ad=1.537 as=1.537 pd=11.18 ps=11.18 nrd=0.0547169811320755
+ nrs=0.0547169811320755 sa=0 sb=0 sd=0 mult=1
.ends

.end
