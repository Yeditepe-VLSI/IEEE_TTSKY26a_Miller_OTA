* SPICE3 file created from tt_um_analog_ota_version1.ext - technology: sky130A

.subckt sky130_fd_pr__nfet_01v8_VUE4HL D S VSUBS
X0 S a_n33_n188# D VSUBS sky130_fd_pr__nfet_01v8 ad=0.29 pd=2.58 as=0.3 ps=2.6 w=1 l=0.15
.ends

.subckt sky130_fd_pr__nfet_01v8_T4AS2N D S G VSUBS
X0 S G D VSUBS sky130_fd_pr__nfet_01v8 ad=0.1885 pd=1.88 as=0.1885 ps=1.88 w=0.65 l=2
.ends

.subckt sky130_fd_pr__nfet_01v8_V5JU8A D S G VSUBS
X0 S G D VSUBS sky130_fd_pr__nfet_01v8 ad=1.45 pd=10.58 as=1.45 ps=10.58 w=5 l=1
.ends

.subckt sky130_fd_pr__pfet_01v8_FQ8SMG D S G w_n194_n630#
X0 S G D w_n194_n630# sky130_fd_pr__pfet_01v8 ad=1.537 pd=11.18 as=1.537 ps=11.18 w=5.3 l=1
.ends

.subckt sky130_fd_pr__pfet_01v8_RAUDFE a_n158_n1000# S a_n100_n1026# w_n194_n1062#
X0 S a_n100_n1026# a_n158_n1000# w_n194_n1062# sky130_fd_pr__pfet_01v8 ad=2.9 pd=20.58 as=2.9 ps=20.58 w=10 l=1
.ends

.subckt sky130_fd_pr__nfet_01v8_S5TDRT D S G VSUBS
X0 S G D VSUBS sky130_fd_pr__nfet_01v8 ad=0.6 pd=4.6 as=0.58 ps=4.58 w=2 l=1
.ends

.subckt sky130_fd_pr__pfet_01v8_lvt_329JWK D w_n144_n144# a_50_n89# a_n50_n115#
X0 a_50_n89# a_n50_n115# D w_n144_n144# sky130_fd_pr__pfet_01v8_lvt ad=0.3625 pd=3.08 as=0.3625 ps=3.08 w=1.25 l=0.5
.ends

.subckt sky130_fd_pr__pfet_01v8_NDNS9K D S G w_n1094_n114#
X0 S G D w_n1094_n114# sky130_fd_pr__pfet_01v8 ad=0.145 pd=1.58 as=0.145 ps=1.58 w=0.5 l=10
.ends

.subckt sky130_fd_pr__cap_mim_m3_1_LVZ2G2 C1 C2
X0 C1 C2 sky130_fd_pr__cap_mim_m3_1 l=10.55 w=10.55
.ends

.subckt sky130_fd_pr__nfet_01v8_T4622N a_200_n96# a_n258_n96# a_n200_n122# VSUBS
X0 a_200_n96# a_n200_n122# a_n258_n96# VSUBS sky130_fd_pr__nfet_01v8 ad=0.1885 pd=1.88 as=0.1885 ps=1.88 w=0.65 l=2
.ends

.subckt sky130_fd_pr__pfet_01v8_AJHSM8 G D w_n194_n628# S
X0 S G D w_n194_n628# sky130_fd_pr__pfet_01v8 ad=1.537 pd=11.18 as=1.537 ps=11.18 w=5.3 l=1
.ends

.subckt sky130_fd_pr__pfet_01v8_S7UDFN D S G w_n194_n1064#
X0 S G D w_n194_n1064# sky130_fd_pr__pfet_01v8 ad=2.9 pd=20.58 as=2.9 ps=20.58 w=10 l=1
.ends

.subckt sky130_fd_pr__nfet_01v8_YYSX75 S27 D22 S17 D10 D20 S15 G S25 S13 S23 S11 S21
+ D8 D6 D4 a_6841_n65# D2 D0 S9 S7 D18 D28 S5 D16 D26 S3 D14 D24 S19 S1 S29 D12 VSUBS
X0 D8 G S7 VSUBS sky130_fd_pr__nfet_01v8 ad=0.09425 pd=0.94 as=0.09425 ps=0.94 w=0.65 l=2
X1 D14 G S13 VSUBS sky130_fd_pr__nfet_01v8 ad=0.09425 pd=0.94 as=0.09425 ps=0.94 w=0.65 l=2
X2 S13 G D12 VSUBS sky130_fd_pr__nfet_01v8 ad=0.09425 pd=0.94 as=0.09425 ps=0.94 w=0.65 l=2
X3 S15 G D14 VSUBS sky130_fd_pr__nfet_01v8 ad=0.09425 pd=0.94 as=0.09425 ps=0.94 w=0.65 l=2
X4 D10 G S9 VSUBS sky130_fd_pr__nfet_01v8 ad=0.09425 pd=0.94 as=0.09425 ps=0.94 w=0.65 l=2
X5 S27 G D26 VSUBS sky130_fd_pr__nfet_01v8 ad=0.09425 pd=0.94 as=0.09425 ps=0.94 w=0.65 l=2
X6 a_6841_n65# G S29 VSUBS sky130_fd_pr__nfet_01v8 ad=0.1885 pd=1.88 as=0.09425 ps=0.94 w=0.65 l=2
X7 S29 G D28 VSUBS sky130_fd_pr__nfet_01v8 ad=0.09425 pd=0.94 as=0.09425 ps=0.94 w=0.65 l=2
X8 D12 G S11 VSUBS sky130_fd_pr__nfet_01v8 ad=0.09425 pd=0.94 as=0.09425 ps=0.94 w=0.65 l=2
X9 S25 G D24 VSUBS sky130_fd_pr__nfet_01v8 ad=0.09425 pd=0.94 as=0.09425 ps=0.94 w=0.65 l=2
X10 S17 G D16 VSUBS sky130_fd_pr__nfet_01v8 ad=0.09425 pd=0.94 as=0.09425 ps=0.94 w=0.65 l=2
X11 D28 G S27 VSUBS sky130_fd_pr__nfet_01v8 ad=0.09425 pd=0.94 as=0.09425 ps=0.94 w=0.65 l=2
X12 D24 G S23 VSUBS sky130_fd_pr__nfet_01v8 ad=0.09425 pd=0.94 as=0.09425 ps=0.94 w=0.65 l=2
X13 S23 G D22 VSUBS sky130_fd_pr__nfet_01v8 ad=0.09425 pd=0.94 as=0.09425 ps=0.94 w=0.65 l=2
X14 D18 G S17 VSUBS sky130_fd_pr__nfet_01v8 ad=0.09425 pd=0.94 as=0.09425 ps=0.94 w=0.65 l=2
X15 D26 G S25 VSUBS sky130_fd_pr__nfet_01v8 ad=0.09425 pd=0.94 as=0.09425 ps=0.94 w=0.65 l=2
X16 D2 G S1 VSUBS sky130_fd_pr__nfet_01v8 ad=0.09425 pd=0.94 as=0.09425 ps=0.94 w=0.65 l=2
X17 D22 G S21 VSUBS sky130_fd_pr__nfet_01v8 ad=0.09425 pd=0.94 as=0.09425 ps=0.94 w=0.65 l=2
X18 S21 G D20 VSUBS sky130_fd_pr__nfet_01v8 ad=0.09425 pd=0.94 as=0.09425 ps=0.94 w=0.65 l=2
X19 S7 G D6 VSUBS sky130_fd_pr__nfet_01v8 ad=0.09425 pd=0.94 as=0.09425 ps=0.94 w=0.65 l=2
X20 S1 G D0 VSUBS sky130_fd_pr__nfet_01v8 ad=0.09425 pd=0.94 as=0.1885 ps=1.88 w=0.65 l=2
X21 D4 G S3 VSUBS sky130_fd_pr__nfet_01v8 ad=0.09425 pd=0.94 as=0.09425 ps=0.94 w=0.65 l=2
X22 D20 G S19 VSUBS sky130_fd_pr__nfet_01v8 ad=0.09425 pd=0.94 as=0.09425 ps=0.94 w=0.65 l=2
X23 S19 G D18 VSUBS sky130_fd_pr__nfet_01v8 ad=0.09425 pd=0.94 as=0.09425 ps=0.94 w=0.65 l=2
X24 S5 G D4 VSUBS sky130_fd_pr__nfet_01v8 ad=0.09425 pd=0.94 as=0.09425 ps=0.94 w=0.65 l=2
X25 D16 G S15 VSUBS sky130_fd_pr__nfet_01v8 ad=0.09425 pd=0.94 as=0.09425 ps=0.94 w=0.65 l=2
X26 S9 G D8 VSUBS sky130_fd_pr__nfet_01v8 ad=0.09425 pd=0.94 as=0.09425 ps=0.94 w=0.65 l=2
X27 D6 G S5 VSUBS sky130_fd_pr__nfet_01v8 ad=0.09425 pd=0.94 as=0.09425 ps=0.94 w=0.65 l=2
X28 S3 G D2 VSUBS sky130_fd_pr__nfet_01v8 ad=0.09425 pd=0.94 as=0.09425 ps=0.94 w=0.65 l=2
X29 S11 G D10 VSUBS sky130_fd_pr__nfet_01v8 ad=0.09425 pd=0.94 as=0.09425 ps=0.94 w=0.65 l=2
.ends

.subckt sky130_fd_pr__pfet_01v8_G9JQ9S D10 G S14 S13 S11 w_n2000_n630# D8 D6 D4 D2
+ D0 S9 S7 S5 S3 D14 S1 D12
X0 S13 G D12 w_n2000_n630# sky130_fd_pr__pfet_01v8 ad=0.7685 pd=5.59 as=0.7685 ps=5.59 w=5.3 l=1
X1 D8 G S7 w_n2000_n630# sky130_fd_pr__pfet_01v8 ad=0.7685 pd=5.59 as=0.7685 ps=5.59 w=5.3 l=1
X2 D6 G S5 w_n2000_n630# sky130_fd_pr__pfet_01v8 ad=0.7685 pd=5.59 as=0.7685 ps=5.59 w=5.3 l=1
X3 S7 G D6 w_n2000_n630# sky130_fd_pr__pfet_01v8 ad=0.7685 pd=5.59 as=0.7685 ps=5.59 w=5.3 l=1
X4 S1 G D0 w_n2000_n630# sky130_fd_pr__pfet_01v8 ad=0.7685 pd=5.59 as=1.537 ps=11.18 w=5.3 l=1
X5 D2 G S1 w_n2000_n630# sky130_fd_pr__pfet_01v8 ad=0.7685 pd=5.59 as=0.7685 ps=5.59 w=5.3 l=1
X6 S3 G D2 w_n2000_n630# sky130_fd_pr__pfet_01v8 ad=0.7685 pd=5.59 as=0.7685 ps=5.59 w=5.3 l=1
X7 S5 G D4 w_n2000_n630# sky130_fd_pr__pfet_01v8 ad=0.7685 pd=5.59 as=0.7685 ps=5.59 w=5.3 l=1
X8 D4 G S3 w_n2000_n630# sky130_fd_pr__pfet_01v8 ad=0.7685 pd=5.59 as=0.7685 ps=5.59 w=5.3 l=1
X9 D10 G S9 w_n2000_n630# sky130_fd_pr__pfet_01v8 ad=0.7685 pd=5.59 as=0.7685 ps=5.59 w=5.3 l=1
X10 S9 G D8 w_n2000_n630# sky130_fd_pr__pfet_01v8 ad=0.7685 pd=5.59 as=0.7685 ps=5.59 w=5.3 l=1
X11 S14 G D14 w_n2000_n630# sky130_fd_pr__pfet_01v8 ad=1.537 pd=11.18 as=0.7685 ps=5.59 w=5.3 l=1
X12 D14 G S13 w_n2000_n630# sky130_fd_pr__pfet_01v8 ad=0.7685 pd=5.59 as=0.7685 ps=5.59 w=5.3 l=1
X13 D12 G S11 w_n2000_n630# sky130_fd_pr__pfet_01v8 ad=0.7685 pd=5.59 as=0.7685 ps=5.59 w=5.3 l=1
X14 S11 G D10 w_n2000_n630# sky130_fd_pr__pfet_01v8 ad=0.7685 pd=5.59 as=0.7685 ps=5.59 w=5.3 l=1
.ends

.subckt sky130_fd_pr__res_xhigh_po_1p41_FFT4WC B R1 R2
X0 R1 R2 B sky130_fd_pr__res_xhigh_po_1p41 l=5.45
.ends

.subckt sky130_fd_pr__nfet_01v8_BDGU8L D2 D0 a_487_n500# S3 S1 VSUBS
X0 a_487_n500# G S3 VSUBS sky130_fd_pr__nfet_01v8 ad=1.45 pd=10.58 as=0.725 ps=5.29 w=5 l=1
X1 D2 G S1 VSUBS sky130_fd_pr__nfet_01v8 ad=0.725 pd=5.29 as=0.725 ps=5.29 w=5 l=1
X2 S3 G D2 VSUBS sky130_fd_pr__nfet_01v8 ad=0.725 pd=5.29 as=0.725 ps=5.29 w=5 l=1
X3 S1 G D0 VSUBS sky130_fd_pr__nfet_01v8 ad=0.725 pd=5.29 as=1.45 ps=10.58 w=5 l=1
.ends

.subckt tt_um_analog_ota_version1 ua[0] ua[1] VDPWR VGND
Xsky130_fd_pr__nfet_01v8_VUE4HL_0 sky130_fd_pr__pfet_01v8_NDNS9K_0/S VGND VGND sky130_fd_pr__nfet_01v8_VUE4HL
Xsky130_fd_pr__nfet_01v8_T4AS2N_0 VGND VGND VGND VGND sky130_fd_pr__nfet_01v8_T4AS2N
Xsky130_fd_pr__nfet_01v8_V5JU8A_0 VGND sky130_fd_pr__pfet_01v8_RAUDFE_1/S sky130_fd_pr__pfet_01v8_RAUDFE_1/S
+ VGND sky130_fd_pr__nfet_01v8_V5JU8A
Xsky130_fd_pr__nfet_01v8_T4AS2N_1 VGND VGND VGND VGND sky130_fd_pr__nfet_01v8_T4AS2N
Xsky130_fd_pr__pfet_01v8_FQ8SMG_0 VDPWR VDPWR VDPWR VDPWR sky130_fd_pr__pfet_01v8_FQ8SMG
Xsky130_fd_pr__pfet_01v8_FQ8SMG_1 VDPWR VDPWR VDPWR VDPWR sky130_fd_pr__pfet_01v8_FQ8SMG
Xsky130_fd_pr__pfet_01v8_RAUDFE_0 VDPWR sky130_fd_pr__pfet_01v8_RAUDFE_0/S sky130_fd_pr__pfet_01v8_RAUDFE_0/S
+ VDPWR sky130_fd_pr__pfet_01v8_RAUDFE
Xsky130_fd_pr__pfet_01v8_RAUDFE_1 VDPWR sky130_fd_pr__pfet_01v8_RAUDFE_1/S sky130_fd_pr__pfet_01v8_RAUDFE_0/S
+ VDPWR sky130_fd_pr__pfet_01v8_RAUDFE
Xsky130_fd_pr__nfet_01v8_S5TDRT_0 sky130_fd_pr__pfet_01v8_G9JQ9S_0/G sky130_fd_pr__pfet_01v8_RAUDFE_1/S
+ sky130_fd_pr__pfet_01v8_NDNS9K_0/S VGND sky130_fd_pr__nfet_01v8_S5TDRT
XM1 M1/D sky130_fd_pr__pfet_01v8_AJHSM8_0/D sky130_fd_pr__pfet_01v8_AJHSM8_0/D ua[1]
+ sky130_fd_pr__pfet_01v8_lvt_329JWK
Xsky130_fd_pr__pfet_01v8_NDNS9K_0 VDPWR sky130_fd_pr__pfet_01v8_NDNS9K_0/S sky130_fd_pr__pfet_01v8_NDNS9K_0/S
+ VDPWR sky130_fd_pr__pfet_01v8_NDNS9K
Xsky130_fd_pr__cap_mim_m3_1_LVZ2G2_0 ua[1] ua[1] sky130_fd_pr__cap_mim_m3_1_LVZ2G2
Xsky130_fd_pr__nfet_01v8_T4622N_0 VGND M1/D M1/D VGND sky130_fd_pr__nfet_01v8_T4622N
Xsky130_fd_pr__nfet_01v8_T4622N_1 VGND sky130_fd_pr__nfet_01v8_YYSX75_0/G a_9361_2271#
+ VGND sky130_fd_pr__nfet_01v8_T4622N
Xsky130_fd_pr__nfet_01v8_T4622N_2 a_3813_2110# sky130_fd_pr__pfet_01v8_AJHSM8_4/D
+ sky130_fd_pr__pfet_01v8_AJHSM8_4/D VGND sky130_fd_pr__nfet_01v8_T4622N
Xsky130_fd_pr__pfet_01v8_AJHSM8_0 sky130_fd_pr__pfet_01v8_G9JQ9S_0/G sky130_fd_pr__pfet_01v8_AJHSM8_0/D
+ VDPWR VDPWR sky130_fd_pr__pfet_01v8_AJHSM8
Xsky130_fd_pr__nfet_01v8_T4622N_3 ua[1] a_3594_1593# sky130_fd_pr__pfet_01v8_AJHSM8_4/D
+ VGND sky130_fd_pr__nfet_01v8_T4622N
Xsky130_fd_pr__pfet_01v8_AJHSM8_1 VDPWR VDPWR VDPWR VDPWR sky130_fd_pr__pfet_01v8_AJHSM8
Xsky130_fd_pr__nfet_01v8_T4622N_4 VGND a_3813_2110# a_3813_2110# VGND sky130_fd_pr__nfet_01v8_T4622N
Xsky130_fd_pr__pfet_01v8_AJHSM8_2 VDPWR VDPWR VDPWR VDPWR sky130_fd_pr__pfet_01v8_AJHSM8
Xsky130_fd_pr__pfet_01v8_AJHSM8_3 VDPWR VDPWR VDPWR VDPWR sky130_fd_pr__pfet_01v8_AJHSM8
Xsky130_fd_pr__pfet_01v8_lvt_329JWK_0 sky130_fd_pr__nfet_01v8_YYSX75_0/G sky130_fd_pr__pfet_01v8_AJHSM8_0/D
+ sky130_fd_pr__pfet_01v8_AJHSM8_0/D ua[0] sky130_fd_pr__pfet_01v8_lvt_329JWK
Xsky130_fd_pr__pfet_01v8_AJHSM8_4 sky130_fd_pr__pfet_01v8_G9JQ9S_0/G sky130_fd_pr__pfet_01v8_AJHSM8_4/D
+ VDPWR VDPWR sky130_fd_pr__pfet_01v8_AJHSM8
Xsky130_fd_pr__pfet_01v8_S7UDFN_1 VDPWR VDPWR VDPWR VDPWR sky130_fd_pr__pfet_01v8_S7UDFN
Xsky130_fd_pr__pfet_01v8_S7UDFN_0 VDPWR VDPWR VDPWR VDPWR sky130_fd_pr__pfet_01v8_S7UDFN
Xsky130_fd_pr__pfet_01v8_AJHSM8_5 VDPWR VDPWR VDPWR VDPWR sky130_fd_pr__pfet_01v8_AJHSM8
Xsky130_fd_pr__nfet_01v8_YYSX75_0 VGND ua[1] VGND ua[1] ua[1] VGND sky130_fd_pr__nfet_01v8_YYSX75_0/G
+ VGND VGND VGND VGND VGND ua[1] ua[1] ua[1] ua[1] ua[1] ua[1] VGND VGND ua[1] ua[1]
+ VGND ua[1] ua[1] VGND ua[1] ua[1] VGND VGND VGND ua[1] VGND sky130_fd_pr__nfet_01v8_YYSX75
Xsky130_fd_pr__pfet_01v8_G9JQ9S_0 VDPWR sky130_fd_pr__pfet_01v8_G9JQ9S_0/G ua[1] ua[1]
+ ua[1] VDPWR VDPWR VDPWR VDPWR VDPWR VDPWR ua[1] ua[1] ua[1] ua[1] VDPWR ua[1] VDPWR
+ sky130_fd_pr__pfet_01v8_G9JQ9S
Xsky130_fd_pr__res_xhigh_po_1p41_FFT4WC_0 VGND sky130_fd_pr__nfet_01v8_BDGU8L_0/S3
+ VGND sky130_fd_pr__res_xhigh_po_1p41_FFT4WC
Xsky130_fd_pr__nfet_01v8_BDGU8L_0 sky130_fd_pr__pfet_01v8_RAUDFE_0/S sky130_fd_pr__pfet_01v8_RAUDFE_0/S
+ sky130_fd_pr__pfet_01v8_RAUDFE_0/S sky130_fd_pr__nfet_01v8_BDGU8L_0/S3 sky130_fd_pr__nfet_01v8_BDGU8L_0/S3
+ VGND sky130_fd_pr__nfet_01v8_BDGU8L
.ends
